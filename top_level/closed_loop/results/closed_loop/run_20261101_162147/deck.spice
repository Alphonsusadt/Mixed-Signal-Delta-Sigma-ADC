* closed-loop Sigma-Delta orde-2 (dibangkitkan run_closed_loop.py)
* stimulus : DC diferensial 0.0 mV
* STATUS   : SIMULATED_NOT_FINAL_PASS bila selesai; tidak ada kriteria pass/fail final.
* bias default = nilai testbench I2 (dikalibrasi untuk stage-2); stage-1 BELUM diverifikasi.

.option scale=1e-6
.option reltol=1e-5 vntol=1e-8 abstol=1e-13
.temp 27.0
.lib /foss/pdks/sky130A/libs.tech/combined/sky130.lib.spice tt

.param cd1=1p cd2=1p

.include /headless/Document/Portfolio_Mixed/top_level/closed_loop/spice/stage1_core.spice
.include /headless/Document/Portfolio_Mixed/top_level/closed_loop/spice/stage2_core.spice
.include /headless/Document/Portfolio_Mixed/top_level/closed_loop/spice/blocks_quantizer_dac.spice
.include /headless/Document/Portfolio_Mixed/top_level/closed_loop/spice/fb_sampler.spice

* ---- supply / referensi / bias ----
VDD vdd 0 1.8
VCM vcm 0 0.9
VREFP vrefp 0 1.2
VREFN vrefn 0 0.6
VBIAS1 vbias1 0 0.58
VBIAS2 vbias2 0 0.58
VCS1 vcs1 0 0.925908120449107
VCS2 vcs2 0 0.925908120449107
VCMS1 vcms1 0 0.60354572
VCMS2 vcms2 0 0.60354572
VBZL vbz_l 0 1.8
VBZR vbz_r 0 1.8

* ---- clock (ideal), reset ----
VPHI1 phi1 0 PULSE(0 1.8 3.000000e-08 1.000000e-09 1.000000e-09 1.100000e-07 2.500000e-07)
VPHI1B phi1b 0 PULSE(1.8 0 3.000000e-08 1.000000e-09 1.000000e-09 1.100000e-07 2.500000e-07)
VPHI2 phi2 0 PULSE(0 1.8 1.550000e-07 1.000000e-09 1.000000e-09 1.100000e-07 2.500000e-07)
VPHI2B phi2b 0 PULSE(1.8 0 1.550000e-07 1.000000e-09 1.000000e-09 1.100000e-07 2.500000e-07)
VCLK clk 0 PULSE(0 1.8 2.000000e-08 1.000000e-09 1.000000e-09 1.100000e-07 2.500000e-07)
VRST rst 0 PWL(0 1.8 2.000000e-05 1.8 2.000100e-05 0 3.625000e-05 0)
VRSTB rstb 0 PWL(0 0 2.000000e-05 0 2.000100e-05 1.8 3.625000e-05 1.8)

* ---- input diferensial ----
VINP vin_p 0 DC 0.9
VINN vin_n 0 DC 0.9

* ---- integrator ----
X1 vin_p vin_n o1_p o1_n s1_p s1_n vo1a_1 vo1b_1 vcmfb_1 vdd vcm vbias1 vbz_l vbz_r vcs1 vcms1 phi1 phi1b phi2 phi2b rst rstb STAGE1
X2 o1_p o1_n o2_p o2_n s2_p s2_n vo1a_2 vo1b_2 vcmfb_2 vdd vcm vbias2 vbz_l vbz_r vcs2 vcms2 phi1 phi1b phi2 phi2b rst rstb STAGE2

* ---- umpan balik DAC -> node sum (tanda: lihat README) ----
XFB1 dac_p dac_n s1_p s1_n vcm phi1 phi1b phi2 phi2b vdd 0 FB_SAMP_SWAP
XFB2 dac_p dac_n s2_p s2_n vcm phi1 phi1b phi2 phi2b vdd 0 FB_SAMP_SWAP

* ---- quantizer -> latch -> DAC (blok 4E apa adanya) ----
XCMP vdd clk cmp_p cmp_n o2_p o2_n 0 StrongARM
XBP vdd cmp_p p_buf 0 BUF_B01
XBN vdd cmp_n n_buf 0 BUF_B01
XSR p_buf n_buf q qb 0 vdd SR_Latch
XDAC vrefp vrefn q qb vdd 0 dac_p dac_n DAC_1bit

.nodeset v(q)=0 v(qb)=1.8
.save v(q) v(qb) v(dac_p) v(dac_n) v(clk) v(phi1) v(phi2) v(cmp_p) v(cmp_n) v(o1_p) v(o1_n) v(o2_p) v(o2_n) v(s1_p) v(s1_n) v(s2_p) v(s2_n) v(vcmfb_1) v(vcmfb_2) v(vo1a_1) v(vo1b_1) v(vo1a_2) v(vo1b_2)

.control
set wr_singlescale
set wr_vecnames
set numdgt=10
tran 1n 3.625000e-05 0 100p
linearize
wrdata waveform.dat v(q) v(qb) v(dac_p) v(dac_n) v(clk) v(phi1) v(phi2) v(cmp_p) v(cmp_n) v(o1_p) v(o1_n) v(o2_p) v(o2_n) v(s1_p) v(s1_n) v(s2_p) v(s2_n) v(vcmfb_1) v(vcmfb_2) v(vo1a_1) v(vo1b_1) v(vo1a_2) v(vo1b_2)
echo CLOSED_LOOP_RUN_DONE
.endc

.end
