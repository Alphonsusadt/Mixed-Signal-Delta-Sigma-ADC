.option scale=1e-6 reltol=1e-5 abstol=1e-15 vntol=1e-8
.temp 125
.lib /foss/pdks/sky130A/libs.tech/combined/sky130.lib.spice ss
.include /headless/Document/Portfolio_Mixed/top_level/closed_loop/spice/b6_nonov.spice
* F5 PVT N=2: clk_cmp = phi2b -> 2 x B6_INV. Load on clk 20f = PLACEHOLDER. bias = res
VDD vdd 0 1.98
RB1 vdd vbn 1.247933e+06 tc1=-1.47e-3 tc2=2.7e-6
XBN1 vbn vbn 0 0 sky130_fd_pr__nfet_01v8 L=1 W=0.5 nf=1 ad=0.145 as=0.145 pd=1.58 ps=1.58 nrd=0.58 nrs=0.58 sa=0 sb=0 sd=0 mult=1
XBN2 vbp vbn 0 0 sky130_fd_pr__nfet_01v8 L=1 W=0.5 nf=1 ad=0.145 as=0.145 pd=1.58 ps=1.58 nrd=0.58 nrs=0.58 sa=0 sb=0 sd=0 mult=1
XBP1 vbp vbp vdd vdd sky130_fd_pr__pfet_01v8 L=1 W=1 nf=1 ad=0.29 as=0.29 pd=2.58 ps=2.58 nrd=0.29 nrs=0.29 sa=0 sb=0 sd=0 mult=1
VCLKM clkm 0 PULSE(1.98 0 15.6n 1n 1n 124n 250n)
XNONOV clkm phi1 phi1b phi2 phi2b vdd vbp 0 vbn B6_NONOV
Vm vm 0 0.99
XLN1A vm phi1 vm 0 sky130_fd_pr__nfet_01v8_lvt W=4 L=0.15 nf=1 mult=1 m=16
XLN1B vm phi1 vm 0 sky130_fd_pr__nfet_01v8 W=2 L=0.15 nf=1 mult=1 m=8
XLP1A vm phi1b vm vdd sky130_fd_pr__pfet_01v8_lvt W=8 L=0.35 nf=1 mult=1 m=16
XLP1B vm phi1b vm vdd sky130_fd_pr__pfet_01v8 W=4 L=0.15 nf=1 mult=1 m=8
XLN2A vm phi2 vm 0 sky130_fd_pr__nfet_01v8_lvt W=4 L=0.15 nf=1 mult=1 m=16
XLN2B vm phi2 vm 0 sky130_fd_pr__nfet_01v8 W=2 L=0.15 nf=1 mult=1 m=8
XLP2A vm phi2b vm vdd sky130_fd_pr__pfet_01v8_lvt W=8 L=0.35 nf=1 mult=1 m=16
XLP2B vm phi2b vm vdd sky130_fd_pr__pfet_01v8 W=4 L=0.15 nf=1 mult=1 m=8
XI1 phi2b c1 vdd 0 B6_INV
XI2 c1 clkc vdd 0 B6_INV
CL clkc 0 20f
.control
tran 0.1n 2u 0 0.1n
echo ===== F5_MEAS =====
meas tran D_P2F_CLKR TRIG v(phi2) VAL=0.99 FALL=1 TD=500n TARG v(clkc) VAL=0.99 RISE=1 TD=500n
meas tran D_P2R_CLKF TRIG v(phi2) VAL=0.99 RISE=1 TD=500n TARG v(clkc) VAL=0.99 FALL=1 TD=500n
meas tran CLK_HIGH TRIG v(clkc) VAL=0.99 RISE=1 TD=500n TARG v(clkc) VAL=0.99 FALL=1 TD=500n
meas tran CLKR_TO_P1R TRIG v(clkc) VAL=0.99 RISE=1 TD=500n TARG v(phi1) VAL=0.99 RISE=1 TD=500n
meas tran TR_CLK TRIG v(clkc) VAL=0.198 RISE=1 TD=500n TARG v(clkc) VAL=1.782 RISE=1 TD=500n
meas tran TF_CLK TRIG v(clkc) VAL=1.782 FALL=1 TD=500n TARG v(clkc) VAL=0.198 FALL=1 TD=500n
meas tran CLK_MAX MAX v(clkc) FROM=500n TO=1.5u
meas tran CLK_MIN MIN v(clkc) FROM=500n TO=1.5u
echo F5_DONE
.endc
.end
